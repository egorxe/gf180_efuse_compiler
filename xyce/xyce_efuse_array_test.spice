.option TEMP=25.0

.include "design.xyce"
.lib "sm141064.xyce" typical
.lib "sm141064.xyce" efuse

.include efuse_array.spice

Xtest COL_PROG[0] DO[0] COL_PROG[1] DO[1] COL_PROG[2] DO[2] COL_PROG[3]
+ DO[3] COL_PROG[4] DO[4] COL_PROG[5] DO[5] COL_PROG[6] DO[6] COL_PROG[7] DO[7] LINE[0]
+ LINE[1] LINE[2] LINE[3] LINE[4] LINE[5] LINE[6] LINE[7] LINE[8] LINE[9] LINE[10]
+ LINE[11] LINE[12] LINE[13] LINE[14] LINE[15] SENSE nPRESET VDD VSS efuse_array

.PREPROCESS REPLACEGROUND TRUE
VVDD VDD GND 5V
VVSS VSS GND 0V

* programming test
VLINE[0] LINE[0] GND 0
VLINE[1] LINE[1] GND 0
VLINE[2] LINE[2] GND 5V
VLINE[3] LINE[3] GND 0
VLINE[4] LINE[4] GND 0
VLINE[5] LINE[5] GND 0
VLINE[6] LINE[6] GND 0
VLINE[7] LINE[7] GND 0
VLINE[8] LINE[8] GND 0
VLINE[9] LINE[9] GND 0
VLINE[10] LINE[10] GND 0
VLINE[11] LINE[11] GND 0
VLINE[12] LINE[12] GND 0
VLINE[13] LINE[13] GND 0
VLINE[14] LINE[14] GND 0
VLINE[15] LINE[15] GND 0
*VLINE[16] LINE[16] GND 0
*VLINE[17] LINE[17] GND 0
*VLINE[18] LINE[18] GND 0
*VLINE[19] LINE[19] GND 0
*VLINE[20] LINE[20] GND 0
*VLINE[21] LINE[21] GND 0
*VLINE[22] LINE[22] GND 0
*VLINE[23] LINE[23] GND 0
*VLINE[24] LINE[24] GND 0
*VLINE[25] LINE[25] GND 0
*VLINE[26] LINE[26] GND 0
*VLINE[27] LINE[27] GND 0
*VLINE[28] LINE[28] GND 0
*VLINE[29] LINE[29] GND 0
*VLINE[30] LINE[30] GND 0
*VLINE[31] LINE[31] GND 0
*VLINE[32] LINE[32] GND 0
*VLINE[33] LINE[33] GND 0
*VLINE[34] LINE[34] GND 0
*VLINE[35] LINE[35] GND 0
*VLINE[36] LINE[36] GND 0
*VLINE[37] LINE[37] GND 0
*VLINE[38] LINE[38] GND 0
*VLINE[39] LINE[39] GND 0
*VLINE[40] LINE[40] GND 0
*VLINE[41] LINE[41] GND 0
*VLINE[42] LINE[42] GND 0
*VLINE[43] LINE[43] GND 0
*VLINE[44] LINE[44] GND 0
*VLINE[45] LINE[45] GND 0
*VLINE[46] LINE[46] GND 0
*VLINE[47] LINE[47] GND 0
*VLINE[48] LINE[48] GND 0
*VLINE[49] LINE[49] GND 0
*VLINE[50] LINE[50] GND 0
*VLINE[51] LINE[51] GND 0
*VLINE[52] LINE[52] GND 0
*VLINE[53] LINE[53] GND 0
*VLINE[54] LINE[54] GND 0
*VLINE[55] LINE[55] GND 0
*VLINE[56] LINE[56] GND 0
*VLINE[57] LINE[57] GND 0
*VLINE[58] LINE[58] GND 0
*VLINE[59] LINE[59] GND 0
*VLINE[60] LINE[60] GND 0
*VLINE[61] LINE[61] GND 0
*VLINE[62] LINE[62] GND 0
*VLINE[63] LINE[63] GND 0

VCOL1_PROG COL_PROG[1] GND 5V
VCOL2_PROG COL_PROG[2] GND 5V
VCOL3_PROG COL_PROG[3] GND 5V
VCOL4_PROG COL_PROG[4] GND 5V
VCOL5_PROG COL_PROG[5] GND 5V
VCOL6_PROG COL_PROG[6] GND 5V
VCOL7_PROG COL_PROG[7] GND 5V

*VCOL0_PROG COL_PROG[0] GND PULSE(5V 0V 1us 10ns 10ns 100ns 100us)

*VPRESET nPRESET GND PULSE(5V 0V 100ns 1ns 1ns 100ns 100us)
*VSENSE SENSE GND 0

* sense test
VCOL0_PROG COL_PROG[0] GND 5V

VPRESET nPRESET GND PULSE(5V 0V 1020ns 1ns 1ns 10ns 100us)
VSENSE SENSE GND PULSE(0 5V 1050ns 1ns 1ns 10ns 10us)

.TRAN 1e-12 1.5e-6
.PRINT TRAN V(DO[0]) V(DO[1]) V(DO[2]) V(DO[3]) V(nPRESET) V(SENSE) V(COL_PROG[0]) I(VVDD) I(XTEST:RFUSE*)
.end
