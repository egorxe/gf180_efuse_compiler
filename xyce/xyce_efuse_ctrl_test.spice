.option TEMP=25.0

.include "design.xyce"
.lib "sm141064.xyce" typical
.lib "sm141064.xyce" efuse
.lib "sm141064.xyce" dio

.include efuse_ctrl.spice

Xtest wb_adr_i[0] wb_adr_i[3] wb_clk_i wb_cyc_i wb_dat_i[0] wb_dat_i[1]
+ wb_dat_i[2] wb_dat_i[4] wb_dat_i[5] wb_dat_i[6] wb_dat_i[7] wb_dat_o[0] wb_dat_o[1]
+ wb_dat_o[3] wb_dat_o[7] wb_rst_i wb_ack_o wb_adr_i[1] wb_adr_i[2] wb_adr_i[4] wb_adr_i[5]
+ wb_adr_i[6] wb_dat_i[3] wb_dat_o[2] wb_dat_o[4] wb_dat_o[5] wb_dat_o[6] wb_sel_i
+ wb_stb_i wb_we_i VSS VDD efuse_ctrl

.PREPROCESS REPLACEGROUND TRUE
VVDD VDD GND 5V
VVSS VSS GND 0V

* programming test

* sense test
Vadr[0] wb_adr_i[0] 0 5V
Vadr[2] wb_adr_i[1] 0 0V
Vadr[3] wb_adr_i[2] 0 5V
Vadr[4] wb_adr_i[3] 0 0V
Vadr[5] wb_adr_i[4] 0 0V
Vadr[6] wb_adr_i[5] 0 0V
Vadr[7] wb_adr_i[6] 0 5V

Vdat[0] wb_dat_i[0] 0 5V
Vdat[1] wb_dat_i[1] 0 0V
Vdat[2] wb_dat_i[2] 0 5V
Vdat[3] wb_dat_i[3] 0 0V
Vdat[4] wb_dat_i[4] 0 5V
Vdat[5] wb_dat_i[5] 0 0V
Vdat[6] wb_dat_i[6] 0 5V
Vdat[7] wb_dat_i[7] 0 0V

Vclk wb_clk_i GND PULSE(0 5V 0us 1ns 1ns 8ns 20ns)

Vwe wb_we_i 0 0V

Vrst wb_rst_i GND PWL 0ns 5V 110ns 5V 111ns 0V
Vstb wb_stb_i GND PWL 0ns 0V 130ns 0V 131ns 5V 150ns 5V 151ns 0V

.TRAN 1e-12 700e-9
.PRINT TRAN V(wb_clk_i) V(wb_rst_i) V(wb_stb_i) V(wb_dat_o[0]) V(wb_dat_o[1]) V(wb_dat_o[2]) V(wb_dat_o[3]) V(wb_dat_o[4]) V(wb_dat_o[5]) V(wb_dat_o[6]) V(wb_dat_o[7]) V(wb_ack_o)
+ I(XTEST:RFUSE*)

* a_10423_5594# - ANODE
* a_21576_5554# - nPRESET
* a_21260_5371# - SENSE
* a_21260_5981# - LATCH_IN

.end
